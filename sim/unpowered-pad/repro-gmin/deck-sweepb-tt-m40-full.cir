* klt sim -- generated corner deck, do not edit
.lib /home/ubuntu/.ciel/sky130A/libs.tech/ngspice/sky130.lib.spice tt
.include ../tb_sweep_b.spice
.temp -40
.meas dc ipadp_max MAX i(vamp)
.meas dc ipadp_min MIN i(vamp)
.meas dc ipadn_max MAX i(vamn)
.meas dc ipadn_min MIN i(vamn)
.meas dc ivccd_max MAX i(vvccd)
.meas dc ivccd_min MIN i(vvccd)
.meas dc ivddio_max MAX i(vvddio)
.meas dc ivddio_min MIN i(vvddio)
.meas dc ivssio_max MAX i(vvssio)
.meas dc ivssio_min MIN i(vvssio)
.meas dc idiff_max MAX par('(i(vamp) - i(vamn)) / 2')
.meas dc idiff_min MIN par('(i(vamp) - i(vamn)) / 2')
.meas dc vcms_max MAX v(xtb.xdrv.vcms)
.meas dc vcms_min MIN v(xtb.xdrv.vcms)
.meas dc ja_main_mspa_d MAX par('v(PADP) - v(xtb.xdrv.xsl_main.well)')
.meas dc ja_main_mspb_d MAX par('v(PADN) - v(xtb.xdrv.xsl_main.well)')
.meas dc ja_main_msp_s MAX par('v(xtb.xdrv.xsl_main.top) - v(xtb.xdrv.xsl_main.well)')
.meas dc ja_main_mwv_s MAX par('v(VCCD) - v(xtb.xdrv.xsl_main.well)')
.meas dc ja_main_mgta_d MAX par('v(xtb.GPA) - v(xtb.xdrv.xsl_main.well)')
.meas dc ja_main_mgtb_d MAX par('v(xtb.GPB) - v(xtb.xdrv.xsl_main.well)')
.meas dc ja_main_nwsub MAX par('v(VSSIO) - v(xtb.xdrv.xsl_main.well)')
.meas dc ja_e0_mspa_d MAX par('v(PADP) - v(xtb.xdrv.xsl_e0.well)')
.meas dc ja_e0_mspb_d MAX par('v(PADN) - v(xtb.xdrv.xsl_e0.well)')
.meas dc ja_e0_msp_s MAX par('v(xtb.xdrv.xsl_e0.top) - v(xtb.xdrv.xsl_e0.well)')
.meas dc ja_e0_mwv_s MAX par('v(VCCD) - v(xtb.xdrv.xsl_e0.well)')
.meas dc ja_e0_mgta_d MAX par('v(xtb.XPA) - v(xtb.xdrv.xsl_e0.well)')
.meas dc ja_e0_mgtb_d MAX par('v(xtb.XPB) - v(xtb.xdrv.xsl_e0.well)')
.meas dc ja_e0_nwsub MAX par('v(VSSIO) - v(xtb.xdrv.xsl_e0.well)')
.meas dc ja_e1a_mspa_d MAX par('v(PADP) - v(xtb.xdrv.xsl_e1a.well)')
.meas dc ja_e1a_mspb_d MAX par('v(PADN) - v(xtb.xdrv.xsl_e1a.well)')
.meas dc ja_e1a_msp_s MAX par('v(xtb.xdrv.xsl_e1a.top) - v(xtb.xdrv.xsl_e1a.well)')
.meas dc ja_e1a_mwv_s MAX par('v(VCCD) - v(xtb.xdrv.xsl_e1a.well)')
.meas dc ja_e1a_mgta_d MAX par('v(xtb.XPA) - v(xtb.xdrv.xsl_e1a.well)')
.meas dc ja_e1a_mgtb_d MAX par('v(xtb.XPB) - v(xtb.xdrv.xsl_e1a.well)')
.meas dc ja_e1a_nwsub MAX par('v(VSSIO) - v(xtb.xdrv.xsl_e1a.well)')
.meas dc ja_e1b_mspa_d MAX par('v(PADP) - v(xtb.xdrv.xsl_e1b.well)')
.meas dc ja_e1b_mspb_d MAX par('v(PADN) - v(xtb.xdrv.xsl_e1b.well)')
.meas dc ja_e1b_msp_s MAX par('v(xtb.xdrv.xsl_e1b.top) - v(xtb.xdrv.xsl_e1b.well)')
.meas dc ja_e1b_mwv_s MAX par('v(VCCD) - v(xtb.xdrv.xsl_e1b.well)')
.meas dc ja_e1b_mgta_d MAX par('v(xtb.XPA) - v(xtb.xdrv.xsl_e1b.well)')
.meas dc ja_e1b_mgtb_d MAX par('v(xtb.XPB) - v(xtb.xdrv.xsl_e1b.well)')
.meas dc ja_e1b_nwsub MAX par('v(VSSIO) - v(xtb.xdrv.xsl_e1b.well)')
.meas dc ja_nsub_padp MAX par('v(VSSIO) - v(PADP)')
.meas dc ja_nsub_padn MAX par('v(VSSIO) - v(PADN)')
.meas dc ja_pre_gpa MAX par('v(xtb.xpre.in_3pma) - v(VCCD)')
.meas dc ja_pre_gpb MAX par('v(xtb.xpre.in_3pmb) - v(VCCD)')
.meas dc ja_pre_gna MAX par('v(xtb.GNA) - v(VCCD)')
.meas dc ja_pre_gnb MAX par('v(xtb.GNB) - v(VCCD)')
.meas dc ja_pre_xpa MAX par('v(xtb.xpre.in_3pea) - v(VCCD)')
.meas dc ja_pre_xpb MAX par('v(xtb.xpre.in_3peb) - v(VCCD)')
.meas dc ja_pre_xna MAX par('v(xtb.XNA) - v(VCCD)')
.meas dc ja_pre_xnb MAX par('v(xtb.XNB) - v(VCCD)')
.meas dc ja_tg_m MAX par('max(max(v(xtb.GPA), v(xtb.GPB)), max(v(xtb.xpre.in_3pma), v(xtb.xpre.in_3pmb))) - v(xtb.xpre.pwm)')
.meas dc ja_tgn_m MAX par('v(VSSIO) - min(min(v(xtb.GPA), v(xtb.GPB)), min(v(xtb.xpre.in_3pma), v(xtb.xpre.in_3pmb)))')
.meas dc pw_m_max MAX v(xtb.xpre.pwm)
.meas dc ja_tg_e MAX par('max(max(v(xtb.XPA), v(xtb.XPB)), max(v(xtb.xpre.in_3pea), v(xtb.xpre.in_3peb))) - v(xtb.xpre.pwe)')
.meas dc ja_tgn_e MAX par('v(VSSIO) - min(min(v(xtb.XPA), v(xtb.XPB)), min(v(xtb.xpre.in_3pea), v(xtb.xpre.in_3peb)))')
.meas dc pw_e_max MAX v(xtb.xpre.pwe)
.meas dc in_pre_max MAX par('max(max(v(xtb.xpre.in_3pma), v(xtb.xpre.in_3pmb)), max(v(xtb.xpre.in_3pea), v(xtb.xpre.in_3peb)))')
.meas dc wt_main MAX par('abs(v(xtb.xdrv.xsl_main.well) - v(VREFMAX))')
.meas dc well_main_max MAX v(xtb.xdrv.xsl_main.well)
.meas dc well_main_min MIN v(xtb.xdrv.xsl_main.well)
.meas dc wt_e0 MAX par('abs(v(xtb.xdrv.xsl_e0.well) - v(VREFMAX))')
.meas dc well_e0_max MAX v(xtb.xdrv.xsl_e0.well)
.meas dc well_e0_min MIN v(xtb.xdrv.xsl_e0.well)
.meas dc wt_e1a MAX par('abs(v(xtb.xdrv.xsl_e1a.well) - v(VREFMAX))')
.meas dc well_e1a_max MAX v(xtb.xdrv.xsl_e1a.well)
.meas dc well_e1a_min MIN v(xtb.xdrv.xsl_e1a.well)
.meas dc wt_e1b MAX par('abs(v(xtb.xdrv.xsl_e1b.well) - v(VREFMAX))')
.meas dc well_e1b_max MAX v(xtb.xdrv.xsl_e1b.well)
.meas dc well_e1b_min MIN v(xtb.xdrv.xsl_e1b.well)
.meas dc gw_main_a MAX par('abs(v(xtb.GPA) - v(xtb.xdrv.xsl_main.well))')
.meas dc gw_main_b MAX par('abs(v(xtb.GPB) - v(xtb.xdrv.xsl_main.well))')
.meas dc gw_e0_a MAX par('abs(v(xtb.XPA) - v(xtb.xdrv.xsl_e0.well))')
.meas dc gw_e0_b MAX par('abs(v(xtb.XPB) - v(xtb.xdrv.xsl_e0.well))')
.meas dc gw_e1a_a MAX par('abs(v(xtb.XPA) - v(xtb.xdrv.xsl_e1a.well))')
.meas dc gw_e1a_b MAX par('abs(v(xtb.XPB) - v(xtb.xdrv.xsl_e1a.well))')
.meas dc gw_e1b_a MAX par('abs(v(xtb.XPA) - v(xtb.xdrv.xsl_e1b.well))')
.meas dc gw_e1b_b MAX par('abs(v(xtb.XPB) - v(xtb.xdrv.xsl_e1b.well))')
.meas dc tox_main_ox MAX v(TOX_MAIN_OX)
.meas dc tox_main_ds MAX v(TOX_MAIN_DS)
.meas dc tox_e0_ox MAX v(TOX_E0_OX)
.meas dc tox_e0_ds MAX v(TOX_E0_DS)
.meas dc tox_e1a_ox MAX v(TOX_E1A_OX)
.meas dc tox_e1a_ds MAX v(TOX_E1A_DS)
.meas dc tox_e1b_ox MAX v(TOX_E1B_OX)
.meas dc tox_e1b_ds MAX v(TOX_E1B_DS)
.meas dc tox_pre_ox MAX v(TOX_PRE_OX)
.meas dc tox_pre_ds MAX v(TOX_PRE_DS)
.meas dc tox_main_db MAX v(TOX_MAIN_DB)
.meas dc tox_e0_db MAX v(TOX_E0_DB)
.meas dc tox_e1a_db MAX v(TOX_E1A_DB)
.meas dc tox_e1b_db MAX v(TOX_E1B_DB)
.meas dc tox_nsub_padp MAX par('abs(v(PADP) - v(VSSIO))')
.meas dc tox_nsub_padn MAX par('abs(v(PADN) - v(VSSIO))')
.meas dc core_max MAX v(CORE_MAX)
.control
save all
dc VPSRC 0.9 1.6 0.005
quit
.endc
.end
