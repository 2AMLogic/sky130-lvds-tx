* Instrumented copies of the committed subckts for the issue-177 branch-current
* trace. Bench-side instrumentation only: every committed netlist is used
* verbatim via .include, and each *_i subckt below is a copy of its committed
* counterpart with 0 V ammeters inserted in series with selected branches.
* Nothing about the circuit changes -- a 0 V source is a short at DC -- and the
* A/B check in sim/unpowered-pad/RECORD.md (every pad-current reading equals
* the committed bench's at the same corner and sweep point) pins that.
*
* Sign convention, used by every ammeter here:
*   V<name> <pad-side-node> <device-side-node> 0
* so i(v<name>) > 0 is current flowing FROM the pad-side node INTO the branch
* -- current LEAVING the pad. KCL at each pad:
*   i(vamp) [into the pad from the driver] = sum of that pad's pad-branch
*   ammeters, each reading out-of-pad current.
*
* Device lines are copied byte-for-byte from the committed netlists except for
* the node the ammeter inserts on; the source of each copy is named beside it.

.include ../../design/lvds_tx_analog.spice

* --- pad_cell (copied from design/pad_cell/pad_cell.spice) ----------------
* PAD-facing branches: the ESD diode XD1 (cathode at PAD) and the ESD nfet
* XMESD (drain at PAD).
.subckt pad_cell_i PAD VSSIO
*.iopin PAD
*.iopin VSSIO
VBR_D1   PAD N_D1   0
VBR_MESD PAD N_MESD 0
XD1  VSSIO N_D1 sky130_fd_pr__diode_pw2nd_11v0 area=64 perim=32
XMESD N_MESD VSSIO VSSIO VSSIO sky130_fd_pr__esd_nfet_g5v0d10v5 L=0.55 W=21.5 nf=1 ad=6.235 as=6.235 pd=43.58 ps=43.58 nrd=0.0135
+ nrs=0.0135 sa=0 sb=0 sd=0 mult=4 m=4
.ends

* --- drv_slice (copied from design/driver/driver.spice) -------------------
* PADP-facing branches: XMSPA (drain), XMSNA (drain), XMWPA (source -- the
* DR-008 well-switch whose source sits on the pad). PADN-facing: XMSPB,
* XMSNB, XMWPB. Internal nets WELL/TOP/BOT keep their committed names so the
* committed observer expressions still resolve.
*
* Rail-side ammeters (slice VCCD ports, driver VCCD/VDDIO ports) were tried
* and deliberately NOT kept: the extra nodes change ngspice's gmin-stepping
* path on this multistable circuit and the fs/125 C Sweep B solve lands on a
* different (symmetric, +/-163 uA) solution than the committed bench's
* (+288/-125 uA). With pad-branch ammeters only, the instrumented bench
* reproduces the committed bench's max/min to every reported digit at that
* corner -- see the A/B table in RECORD.md. Rail attribution therefore comes
* from the committed top-level rail ammeters, not per-branch ones.
.subckt drv_slice_i GPA GPB GNA GNB PG NG OUTP OUTN VCCD VDDIO VSSIO  SCALE=1
*.ipin GPA
*.ipin GPB
*.ipin GNA
*.ipin GNB
*.ipin PG
*.ipin NG
*.iopin OUTP
*.iopin OUTN
*.iopin VCCD
*.iopin VDDIO
*.iopin VSSIO
VBR_MSPA OUTP N_MSPA 0
VBR_MSNA OUTP N_MSNA 0
VBR_MWPA OUTP N_MWPA 0
VBR_MSPB OUTN N_MSPB 0
VBR_MSNB OUTN N_MSNB 0
VBR_MWPB OUTN N_MWPB 0
XMPS TOP PG VDDIO VDDIO sky130_fd_pr__pfet_g5v0d10v5 L=1 W=12.8 nf=2 ad=1.856 as=3.712 pd=13.38 ps=26.76 nrd=0.0227 nrs=0.0227 sa=0 sb=0 sd=0 mult={SCALE} m={SCALE}
XMSPA N_MSPA GPA TOP WELL sky130_fd_pr__pfet_01v8 L=0.15 W=3.6 nf=4 ad=0.522 as=0.783 pd=4.76 ps=7.14 nrd=0.0806
+ nrs=0.0806 sa=0 sb=0 sd=0 mult={SCALE} m={SCALE}
XMSPB N_MSPB GPB TOP WELL sky130_fd_pr__pfet_01v8 L=0.15 W=3.6 nf=4 ad=0.522 as=0.783 pd=4.76 ps=7.14 nrd=0.0806
+ nrs=0.0806 sa=0 sb=0 sd=0 mult={SCALE} m={SCALE}
XMSNA N_MSNA GNA BOT VSSIO sky130_fd_pr__nfet_01v8 L=0.15 W=2.7 nf=3 ad=0.522 as=0.522 pd=4.76 ps=4.76
+ nrd=0.1074 nrs=0.1074 sa=0 sb=0 sd=0 mult={SCALE} m={SCALE}
XMSNB N_MSNB GNB BOT VSSIO sky130_fd_pr__nfet_01v8 L=0.15 W=2.7 nf=3 ad=0.522 as=0.522 pd=4.76 ps=4.76
+ nrd=0.1074 nrs=0.1074 sa=0 sb=0 sd=0 mult={SCALE} m={SCALE}
XMNS BOT NG VSSIO VSSIO sky130_fd_pr__nfet_g5v0d10v5 L=1 W=6 nf=1 ad=1.74 as=1.74 pd=12.58 ps=12.58 nrd=0.0483
+ nrs=0.0483 sa=0 sb=0 sd=0 mult={SCALE} m={SCALE}
XMWVA WELL OUTP VCCD WELL sky130_fd_pr__pfet_g5v0d10v5 L=0.5 W=0.5 nf=1 ad=0.145 as=0.145 pd=1.58
+ ps=1.58 nrd=0.58 nrs=0.58 sa=0 sb=0 sd=0 mult=1 m=1
XMWVB WELL OUTN VCCD WELL sky130_fd_pr__pfet_g5v0d10v5 L=0.5 W=0.5 nf=1 ad=0.145 as=0.145 pd=1.58
+ ps=1.58 nrd=0.58 nrs=0.58 sa=0 sb=0 sd=0 mult=1 m=1
XMWPA WELL VCCD N_MWPA WELL sky130_fd_pr__pfet_g5v0d10v5 L=0.5 W=0.5 nf=1 ad=0.145 as=0.145 pd=1.58
+ ps=1.58 nrd=0.58 nrs=0.58 sa=0 sb=0 sd=0 mult=1 m=1
XMWPB WELL VCCD N_MWPB WELL sky130_fd_pr__pfet_g5v0d10v5 L=0.5 W=0.5 nf=1 ad=0.145 as=0.145 pd=1.58
+ ps=1.58 nrd=0.58 nrs=0.58 sa=0 sb=0 sd=0 mult=1 m=1
XMGTA GPA VCCD WELL WELL sky130_fd_pr__pfet_g5v0d10v5 L=0.5 W=0.5 nf=1 ad=0.145 as=0.145 pd=1.58
+ ps=1.58 nrd=0.58 nrs=0.58 sa=0 sb=0 sd=0 mult=1 m=1
XMGTB GPB VCCD WELL WELL sky130_fd_pr__pfet_g5v0d10v5 L=0.5 W=0.5 nf=1 ad=0.145 as=0.145 pd=1.58
+ ps=1.58 nrd=0.58 nrs=0.58 sa=0 sb=0 sd=0 mult=1 m=1
.ends

* --- driver (copied from design/driver/driver.spice) ----------------------
* The two sense resistors XRS1/XRS2 are ammetered on their pad terminals and
* the four slices become drv_slice_i (unchanged port list and instance names,
* so observer paths xtb.xdrv.xsl_*.<net> are preserved). No rail renames: see
* the note in the drv_slice_i header.
.subckt driver_i GPA GPB GNA GNB XPA XPB XNA XNB EN EM0 EM1 IREF VCMREF OUTP OUTN VCCD VDDIO VSSIO
*.ipin GPA
*.ipin GPB
*.ipin GNA
*.ipin GNB
*.ipin XPA
*.ipin XPB
*.ipin XNA
*.ipin XNB
*.ipin EN
*.ipin EM0
*.ipin EM1
*.ipin IREF
*.ipin VCMREF
*.iopin OUTP
*.iopin OUTN
*.iopin VCCD
*.iopin VDDIO
*.iopin VSSIO
VBR_XRS1 OUTP N_RS1 0
VBR_XRS2 OUTN N_RS2 0
XMNB1 IREF IREF VSSIO VSSIO sky130_fd_pr__nfet_g5v0d10v5 L=1 W=2 nf=1 ad=0.58 as=0.58 pd=4.58 ps=4.58 nrd=0.145 nrs=0.145 sa=0 sb=0 sd=0 mult=1 m=1
XMNB2 BIASP IREF VSSIO VSSIO sky130_fd_pr__nfet_g5v0d10v5 L=1 W=2 nf=1 ad=0.58 as=0.58 pd=4.58 ps=4.58 nrd=0.145 nrs=0.145 sa=0 sb=0 sd=0 mult=1 m=1
XMPB BIASP BIASP VDDIO VDDIO sky130_fd_pr__pfet_g5v0d10v5 L=1 W=2 nf=1 ad=0.58 as=0.58 pd=4.58 ps=4.58 nrd=0.145 nrs=0.145 sa=0 sb=0 sd=0 mult=1 m=1
XMT TAIL IREF VSSIO VSSIO sky130_fd_pr__nfet_g5v0d10v5 L=1 W=4 nf=1 ad=1.16 as=1.16 pd=8.58 ps=8.58 nrd=0.0725 nrs=0.0725 sa=0 sb=0 sd=0 mult=1 m=1
XM1 N1 VCMS TAIL VSSIO sky130_fd_pr__nfet_g5v0d10v5 L=1 W=10 nf=1 ad=2.9 as=2.9 pd=20.58 ps=20.58 nrd=0.029 nrs=0.029 sa=0 sb=0 sd=0 mult=1 m=1
XM2 VCMFB VCMREF TAIL VSSIO sky130_fd_pr__nfet_g5v0d10v5 L=1 W=10 nf=1 ad=2.9 as=2.9 pd=20.58 ps=20.58 nrd=0.029 nrs=0.029 sa=0 sb=0 sd=0 mult=1 m=1
XML1 N1 N1 VDDIO VDDIO sky130_fd_pr__pfet_g5v0d10v5 L=1 W=4 nf=1 ad=1.16 as=1.16 pd=8.58 ps=8.58 nrd=0.0725 nrs=0.0725 sa=0 sb=0 sd=0 mult=1 m=1
XML2 VCMFB N1 VDDIO VDDIO sky130_fd_pr__pfet_g5v0d10v5 L=1 W=4 nf=1 ad=1.16 as=1.16 pd=8.58 ps=8.58 nrd=0.0725 nrs=0.0725 sa=0 sb=0 sd=0 mult=1 m=1
XCC VSSIO VCMFB VSSIO VSSIO sky130_fd_pr__nfet_g5v0d10v5 L=2 W=20 nf=1 ad=5.8 as=5.8 pd=40.58 ps=40.58 nrd=0.0145 nrs=0.0145 sa=0 sb=0 sd=0 mult=1 m=1
XRS1 VCMS N_RS1 VSSIO sky130_fd_pr__res_high_po_1p41 L=150 mult=1 m=1
XRS2 VCMS N_RS2 VSSIO sky130_fd_pr__res_high_po_1p41 L=150 mult=1 m=1
xsel_en EN BIASP VCMFB PGM NGM VCCD VDDIO VSSIO drv_sel
xsel_e0 EM0 BIASP VCMFB PGE0 NGE0 VCCD VDDIO VSSIO drv_sel
xsel_e1 EM1 BIASP VCMFB PGE1 NGE1 VCCD VDDIO VSSIO drv_sel
xsl_main GPA GPB GNA GNB PGM NGM OUTP OUTN VCCD VDDIO VSSIO drv_slice_i SCALE=11
xsl_e0 XPA XPB XNA XNB PGE0 NGE0 OUTP OUTN VCCD VDDIO VSSIO drv_slice_i SCALE=1
xsl_e1a XPA XPB XNA XNB PGE1 NGE1 OUTP OUTN VCCD VDDIO VSSIO drv_slice_i SCALE=1
xsl_e1b XPA XPB XNA XNB PGE1 NGE1 OUTP OUTN VCCD VDDIO VSSIO drv_slice_i SCALE=1
.ends

* --- lvds_tx_analog (copied from design/lvds_tx_analog.spice) -------------
* Identical wiring and instance names; xdrv becomes driver_i and the pad
* cells become pad_cell_i. xmux/xmuxp/xpre stay the committed subckts.
.subckt lvds_tx_analog_i D0 D0B D1 D1B CLK EN EM0 EM1 IREF VCMREF PADP PADN VCCD VDDIO VSSIO
*.ipin D0
*.ipin D0B
*.ipin D1
*.ipin D1B
*.ipin CLK
*.ipin EN
*.ipin EM0
*.ipin EM1
*.ipin IREF
*.ipin VCMREF
*.iopin PADP
*.iopin PADN
*.iopin VCCD
*.iopin VDDIO
*.iopin VSSIO
xmux D0 D0B D1 D1B CLK Q QB VCCD VSSIO ddr_mux
xmuxp D1 D1B D0 D0B CLK PREV PREVB VCCD VSSIO ddr_mux
xpre Q QB PREVB PREV EN GPA GNA GPB GNB XPA XNA XPB XNB VCCD VSSIO predriver
xdrv GPA GPB GNA GNB XPA XPB XNA XNB EN EM0 EM1 IREF VCMREF PADP PADN VCCD VDDIO VSSIO driver_i
xpadp PADP VSSIO pad_cell_i
xpadn PADN VSSIO pad_cell_i
.ends
