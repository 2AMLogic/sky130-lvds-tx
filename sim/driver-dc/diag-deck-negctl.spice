* Driver DC bench -- V_OD and V_OS in both static data states (spec rows E1-E4).
*
* Simulated, not measured. Grades the committed `driver` subcircuit's draft
* sizing against the PROPOSED spec; it changes no device, bias or schematic.
*
* Two `driver` instances share the rails and the IREF/VCMREF stimulus so that
* dV_OD (E3) and dV_OS (E4, DC half) are differences taken at the SAME PVT
* condition, as the spec's wording requires -- no join across corner records.
*
*   instance 1 -- data state 1: side A gates low,  side B gates high
*   instance 0 -- data state 0: side A gates high, side B gates low
*
* Pre-emphasis is disabled (EM0 = EM1 = 0 V) and the driver is enabled
* (EN = VCCD); see `sim/driver-dc/RECORD.md` for the derivation of both.
*
* E1/E2 are specified at the pad. The corrected `pad_cell` (cd0c89a, PR #108)
* IS instantiated on all four output nodes -- see the pad-cell block at the end
* of this deck. `pad_cell` is a shunt-only network with no series element, so
* the driver output and the pad are the same node at DC and the graded
* expressions read those nodes unchanged. (The cell committed when this bench
* was first recorded had an ESD diode that shunted 107 mA at 1.25 V DC and was
* then deliberately omitted; see `sim/driver-dc/RECORD.md` for that evidence
* and for the re-run record with the corrected cell attached, issue #116.)
*
* Circuit body only: klt sim supplies .lib/.temp/.control (no .end here).

.include ../../design/driver/driver.spice
.include ../../design/pad_cell/pad_cell.spice

* ---------------------------------------------------------------------------
* Rails. `corners.supply_v` in request.json is keyed by these two source
* names, so the five G75 (VCCD, VDDIO) pairs move as a set.
* ---------------------------------------------------------------------------
VVCCD  vccd  0 DC 1.8
VVDDIO vddio 0 DC 3.3

* ---------------------------------------------------------------------------
* Ideal external references (DR-007: every ideal source is labelled as one).
*   vcmref -- the CMFB target, held at 1.25 V at every condition (E2's
*             regulation target, the centre of the TIA/EIA-644 window).
*   iref   -- one DC current forced into each instance's diode-connected
*             XMNB1, chosen once at tt/27 C/1.80 V/3.30 V and then FROZEN
*             across all 75 conditions, so a failing corner stays a recorded
*             miss rather than a tuned-away one.
*
* vcmref is one shared source because it is a VOLTAGE: both instances see
* 1.25 V. iref is one source PER INSTANCE at the same value, because a single
* shared current source would divide its current between the two instances'
* XMNB1 devices and bias each at half the intended value.
* ---------------------------------------------------------------------------
VVCMREF vcmref 0 DC 1.35
IIREF1  0 iref1 DC 54.3u
IIREF0  0 iref0 DC 54.3u

* ---------------------------------------------------------------------------
* Instance 1 -- data state 1 (side A low, side B high => v(outp1) > v(outn1)).
*
* Port order is the committed `driver` order and is NOT the predriver's:
*   GPA GPB GNA GNB  XPA XPB XNA XNB  EN EM0 EM1  IREF VCMREF
*   OUTP OUTN  VCCD VDDIO VSSIO
*
* GPA/GNA share one node and GPB/GNB share the other: the predriver's final
* stage per side is a rail-to-rail CMOS inverter on VCCD/VSSIO driving both
* gates of that side from the same node, so the static gate-drive levels are
* exactly 0 V and VCCD and they track the swept rail with no extra source.
*
* XPA/XPB/XNA/XNB repeat the main slice's pattern, keeping the three disabled
* pre-emphasis slices' switch nodes defined (E8: one switch of each pair is
* always on).
* ---------------------------------------------------------------------------
xdrv1 0 vccd 0 vccd  0 vccd 0 vccd  vccd 0 0  iref1 vcmref
+ outp1 outn1  vccd vddio 0  driver

RL1 outp1 outn1 100

* ---------------------------------------------------------------------------
* Instance 0 -- data state 0 (side A high, side B low => v(outn0) > v(outp0)).
* ---------------------------------------------------------------------------
xdrv0 vccd 0 vccd 0  vccd 0 vccd 0  vccd 0 0  iref0 vcmref
+ outp0 outn0  vccd vddio 0  driver

RL0 outp0 outn0 100

* ---------------------------------------------------------------------------
* Pad cells on the pad nodes (issue #116). The corrected `pad_cell` (cd0c89a,
* PR #108; measured worst reverse shunt at the LVDS common mode 2.04 nA,
* sim/pad-dc/RECORD.md) is instantiated on ALL FOUR output nodes --
* outp1, outn1, outp0, outn0 -- identically, so neither instance nor side is
* favoured: pad_cell is a shunt-only network (one reverse-biased diode, one
* grounded-gate ESD nfet, both PAD->VSSIO) with NO series element, so these
* nodes ARE the pad nodes and the graded expressions need no change. Asymmetric
* instantiation would manufacture a spurious dV_OD/dV_OS out of this bench's
* own mirror asymmetry (see RECORD.md, "Read E3 and E4 with care").
*
* Each VPC* is an IDEAL 0 V source used as an ammeter in the SHUNT branch
* (DR-007: every ideal source is labelled as one) -- a short at DC, so it adds
* no series impedance to the graded node. It sits between the pad node and the
* cell's PAD pin, so it carries only the cell's shunt current, not the 100 ohm
* load current: RL1/RL0 stay directly across the pad nodes.
* ---------------------------------------------------------------------------
VPCP1 outp1 pcp1 DC 0
XPADP1 pcp1 0 pad_cell
VPCN1 outn1 pcn1 DC 0
XPADN1 pcn1 0 pad_cell
VPCP0 outp0 pcp0 DC 0
XPADP0 pcp0 0 pad_cell
VPCN0 outn0 pcn0 DC 0
XPADN0 pcn0 0 pad_cell
