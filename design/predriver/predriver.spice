** sch_path: /home/ubuntu/GitHub/sky130-lvds-tx/.loom/worktrees/issue-20/design/predriver/predriver.sch
.subckt predriver Q QB PQ PQB EN GPA GNA GPB GNB XPA XNA XPB XNB VCCD VSSIO
*.ipin Q
*.ipin QB
*.ipin PQ
*.ipin PQB
*.ipin EN
*.opin GPA
*.opin GNA
*.opin GPB
*.opin GNB
*.opin XPA
*.opin XNA
*.opin XPB
*.opin XNB
*.iopin VCCD
*.iopin VSSIO
XMP_enb ENB EN VCCD VCCD sky130_fd_pr__pfet_01v8 L=0.15 W=1 nf=1 ad=0.29 as=0.29 pd=2.58 ps=2.58
+ nrd=0.29 nrs=0.29 sa=0 sb=0 sd=0 mult=1 m=1
XMN_enb ENB EN VSSIO VSSIO sky130_fd_pr__nfet_01v8 L=0.15 W=0.5 nf=1 ad=0.145 as=0.145 pd=1.58
+ ps=1.58 nrd=0.58 nrs=0.58 sa=0 sb=0 sd=0 mult=1 m=1
XMPA_gma g_ma QB VCCD VCCD sky130_fd_pr__pfet_01v8 L=0.15 W=1 nf=1 ad=0.29 as=0.29 pd=2.58 ps=2.58
+ nrd=0.29 nrs=0.29 sa=0 sb=0 sd=0 mult=1 m=1
XMPB_gma g_ma EN VCCD VCCD sky130_fd_pr__pfet_01v8 L=0.15 W=1 nf=1 ad=0.29 as=0.29 pd=2.58 ps=2.58
+ nrd=0.29 nrs=0.29 sa=0 sb=0 sd=0 mult=1 m=1
XMNA_gma g_ma QB n_gma VSSIO sky130_fd_pr__nfet_01v8 L=0.15 W=1 nf=1 ad=0.29 as=0.29 pd=2.58 ps=2.58
+ nrd=0.29 nrs=0.29 sa=0 sb=0 sd=0 mult=1 m=1
XMNB_gma n_gma EN VSSIO VSSIO sky130_fd_pr__nfet_01v8 L=0.15 W=1 nf=1 ad=0.29 as=0.29 pd=2.58
+ ps=2.58 nrd=0.29 nrs=0.29 sa=0 sb=0 sd=0 mult=1 m=1
XMP_1ma s1_ma g_ma VCCD VCCD sky130_fd_pr__pfet_01v8 L=0.15 W=1 nf=1 ad=0.29 as=0.29 pd=2.58 ps=2.58
+ nrd=0.29 nrs=0.29 sa=0 sb=0 sd=0 mult=1 m=1
XMN_1ma s1_ma g_ma VSSIO VSSIO sky130_fd_pr__nfet_01v8 L=0.15 W=0.5 nf=1 ad=0.145 as=0.145 pd=1.58
+ ps=1.58 nrd=0.58 nrs=0.58 sa=0 sb=0 sd=0 mult=1 m=1
XMP_2ma s2_ma s1_ma VCCD VCCD sky130_fd_pr__pfet_01v8 L=0.15 W=2 nf=1 ad=0.58 as=0.58 pd=4.58
+ ps=4.58 nrd=0.145 nrs=0.145 sa=0 sb=0 sd=0 mult=1 m=1
XMN_2ma s2_ma s1_ma VSSIO VSSIO sky130_fd_pr__nfet_01v8 L=0.15 W=1 nf=1 ad=0.29 as=0.29 pd=2.58
+ ps=2.58 nrd=0.29 nrs=0.29 sa=0 sb=0 sd=0 mult=1 m=1
XMP_3pma GPA s2_ma VCCD VCCD sky130_fd_pr__pfet_01v8 L=0.15 W=11 nf=2 ad=1.595 as=3.19 pd=11.58
+ ps=23.16 nrd=0.0264 nrs=0.0264 sa=0 sb=0 sd=0 mult=1 m=1
XMN_3pma GPA s2_ma VSSIO VSSIO sky130_fd_pr__nfet_01v8 L=0.15 W=5.5 nf=1 ad=1.595 as=1.595 pd=11.58
+ ps=11.58 nrd=0.0527 nrs=0.0527 sa=0 sb=0 sd=0 mult=1 m=1
XMP_3nma GNA s2_ma VCCD VCCD sky130_fd_pr__pfet_01v8 L=0.15 W=11 nf=2 ad=1.595 as=3.19 pd=11.58
+ ps=23.16 nrd=0.0264 nrs=0.0264 sa=0 sb=0 sd=0 mult=1 m=1
XMN_3nma GNA s2_ma VSSIO VSSIO sky130_fd_pr__nfet_01v8 L=0.15 W=5.5 nf=1 ad=1.595 as=1.595 pd=11.58
+ ps=11.58 nrd=0.0527 nrs=0.0527 sa=0 sb=0 sd=0 mult=1 m=1
XMPA_gmb n_gmb Q VCCD VCCD sky130_fd_pr__pfet_01v8 L=0.15 W=2 nf=1 ad=0.58 as=0.58 pd=4.58 ps=4.58
+ nrd=0.145 nrs=0.145 sa=0 sb=0 sd=0 mult=1 m=1
XMPB_gmb g_mb ENB n_gmb VCCD sky130_fd_pr__pfet_01v8 L=0.15 W=2 nf=1 ad=0.58 as=0.58 pd=4.58 ps=4.58
+ nrd=0.145 nrs=0.145 sa=0 sb=0 sd=0 mult=1 m=1
XMNA_gmb g_mb Q VSSIO VSSIO sky130_fd_pr__nfet_01v8 L=0.15 W=0.5 nf=1 ad=0.145 as=0.145 pd=1.58
+ ps=1.58 nrd=0.58 nrs=0.58 sa=0 sb=0 sd=0 mult=1 m=1
XMNB_gmb g_mb ENB VSSIO VSSIO sky130_fd_pr__nfet_01v8 L=0.15 W=0.5 nf=1 ad=0.145 as=0.145 pd=1.58
+ ps=1.58 nrd=0.58 nrs=0.58 sa=0 sb=0 sd=0 mult=1 m=1
XMP_1mb s1_mb g_mb VCCD VCCD sky130_fd_pr__pfet_01v8 L=0.15 W=1 nf=1 ad=0.29 as=0.29 pd=2.58 ps=2.58
+ nrd=0.29 nrs=0.29 sa=0 sb=0 sd=0 mult=1 m=1
XMN_1mb s1_mb g_mb VSSIO VSSIO sky130_fd_pr__nfet_01v8 L=0.15 W=0.5 nf=1 ad=0.145 as=0.145 pd=1.58
+ ps=1.58 nrd=0.58 nrs=0.58 sa=0 sb=0 sd=0 mult=1 m=1
XMP_2mb s2_mb s1_mb VCCD VCCD sky130_fd_pr__pfet_01v8 L=0.15 W=2 nf=1 ad=0.58 as=0.58 pd=4.58
+ ps=4.58 nrd=0.145 nrs=0.145 sa=0 sb=0 sd=0 mult=1 m=1
XMN_2mb s2_mb s1_mb VSSIO VSSIO sky130_fd_pr__nfet_01v8 L=0.15 W=1 nf=1 ad=0.29 as=0.29 pd=2.58
+ ps=2.58 nrd=0.29 nrs=0.29 sa=0 sb=0 sd=0 mult=1 m=1
XMP_3pmb GPB s2_mb VCCD VCCD sky130_fd_pr__pfet_01v8 L=0.15 W=11 nf=2 ad=1.595 as=3.19 pd=11.58
+ ps=23.16 nrd=0.0264 nrs=0.0264 sa=0 sb=0 sd=0 mult=1 m=1
XMN_3pmb GPB s2_mb VSSIO VSSIO sky130_fd_pr__nfet_01v8 L=0.15 W=5.5 nf=1 ad=1.595 as=1.595 pd=11.58
+ ps=11.58 nrd=0.0527 nrs=0.0527 sa=0 sb=0 sd=0 mult=1 m=1
XMP_3nmb GNB s2_mb VCCD VCCD sky130_fd_pr__pfet_01v8 L=0.15 W=11 nf=2 ad=1.595 as=3.19 pd=11.58
+ ps=23.16 nrd=0.0264 nrs=0.0264 sa=0 sb=0 sd=0 mult=1 m=1
XMN_3nmb GNB s2_mb VSSIO VSSIO sky130_fd_pr__nfet_01v8 L=0.15 W=5.5 nf=1 ad=1.595 as=1.595 pd=11.58
+ ps=11.58 nrd=0.0527 nrs=0.0527 sa=0 sb=0 sd=0 mult=1 m=1
XMPA_gea g_ea PQB VCCD VCCD sky130_fd_pr__pfet_01v8 L=0.15 W=1 nf=1 ad=0.29 as=0.29 pd=2.58 ps=2.58
+ nrd=0.29 nrs=0.29 sa=0 sb=0 sd=0 mult=1 m=1
XMPB_gea g_ea EN VCCD VCCD sky130_fd_pr__pfet_01v8 L=0.15 W=1 nf=1 ad=0.29 as=0.29 pd=2.58 ps=2.58
+ nrd=0.29 nrs=0.29 sa=0 sb=0 sd=0 mult=1 m=1
XMNA_gea g_ea PQB n_gea VSSIO sky130_fd_pr__nfet_01v8 L=0.15 W=1 nf=1 ad=0.29 as=0.29 pd=2.58
+ ps=2.58 nrd=0.29 nrs=0.29 sa=0 sb=0 sd=0 mult=1 m=1
XMNB_gea n_gea EN VSSIO VSSIO sky130_fd_pr__nfet_01v8 L=0.15 W=1 nf=1 ad=0.29 as=0.29 pd=2.58
+ ps=2.58 nrd=0.29 nrs=0.29 sa=0 sb=0 sd=0 mult=1 m=1
XMP_1ea s1_ea g_ea VCCD VCCD sky130_fd_pr__pfet_01v8 L=0.15 W=1 nf=1 ad=0.29 as=0.29 pd=2.58 ps=2.58
+ nrd=0.29 nrs=0.29 sa=0 sb=0 sd=0 mult=1 m=1
XMN_1ea s1_ea g_ea VSSIO VSSIO sky130_fd_pr__nfet_01v8 L=0.15 W=0.5 nf=1 ad=0.145 as=0.145 pd=1.58
+ ps=1.58 nrd=0.58 nrs=0.58 sa=0 sb=0 sd=0 mult=1 m=1
XMP_2ea s2_ea s1_ea VCCD VCCD sky130_fd_pr__pfet_01v8 L=0.15 W=2 nf=1 ad=0.58 as=0.58 pd=4.58
+ ps=4.58 nrd=0.145 nrs=0.145 sa=0 sb=0 sd=0 mult=1 m=1
XMN_2ea s2_ea s1_ea VSSIO VSSIO sky130_fd_pr__nfet_01v8 L=0.15 W=1 nf=1 ad=0.29 as=0.29 pd=2.58
+ ps=2.58 nrd=0.29 nrs=0.29 sa=0 sb=0 sd=0 mult=1 m=1
XMP_3pea XPA s2_ea VCCD VCCD sky130_fd_pr__pfet_01v8 L=0.15 W=1 nf=1 ad=0.29 as=0.29 pd=2.58 ps=2.58
+ nrd=0.29 nrs=0.29 sa=0 sb=0 sd=0 mult=1 m=1
XMN_3pea XPA s2_ea VSSIO VSSIO sky130_fd_pr__nfet_01v8 L=0.15 W=0.5 nf=1 ad=0.145 as=0.145 pd=1.58
+ ps=1.58 nrd=0.58 nrs=0.58 sa=0 sb=0 sd=0 mult=1 m=1
XMP_3nea XNA s2_ea VCCD VCCD sky130_fd_pr__pfet_01v8 L=0.15 W=1 nf=1 ad=0.29 as=0.29 pd=2.58 ps=2.58
+ nrd=0.29 nrs=0.29 sa=0 sb=0 sd=0 mult=1 m=1
XMN_3nea XNA s2_ea VSSIO VSSIO sky130_fd_pr__nfet_01v8 L=0.15 W=0.5 nf=1 ad=0.145 as=0.145 pd=1.58
+ ps=1.58 nrd=0.58 nrs=0.58 sa=0 sb=0 sd=0 mult=1 m=1
XMPA_geb n_geb PQ VCCD VCCD sky130_fd_pr__pfet_01v8 L=0.15 W=2 nf=1 ad=0.58 as=0.58 pd=4.58 ps=4.58
+ nrd=0.145 nrs=0.145 sa=0 sb=0 sd=0 mult=1 m=1
XMPB_geb g_eb ENB n_geb VCCD sky130_fd_pr__pfet_01v8 L=0.15 W=2 nf=1 ad=0.58 as=0.58 pd=4.58 ps=4.58
+ nrd=0.145 nrs=0.145 sa=0 sb=0 sd=0 mult=1 m=1
XMNA_geb g_eb PQ VSSIO VSSIO sky130_fd_pr__nfet_01v8 L=0.15 W=0.5 nf=1 ad=0.145 as=0.145 pd=1.58
+ ps=1.58 nrd=0.58 nrs=0.58 sa=0 sb=0 sd=0 mult=1 m=1
XMNB_geb g_eb ENB VSSIO VSSIO sky130_fd_pr__nfet_01v8 L=0.15 W=0.5 nf=1 ad=0.145 as=0.145 pd=1.58
+ ps=1.58 nrd=0.58 nrs=0.58 sa=0 sb=0 sd=0 mult=1 m=1
XMP_1eb s1_eb g_eb VCCD VCCD sky130_fd_pr__pfet_01v8 L=0.15 W=1 nf=1 ad=0.29 as=0.29 pd=2.58 ps=2.58
+ nrd=0.29 nrs=0.29 sa=0 sb=0 sd=0 mult=1 m=1
XMN_1eb s1_eb g_eb VSSIO VSSIO sky130_fd_pr__nfet_01v8 L=0.15 W=0.5 nf=1 ad=0.145 as=0.145 pd=1.58
+ ps=1.58 nrd=0.58 nrs=0.58 sa=0 sb=0 sd=0 mult=1 m=1
XMP_2eb s2_eb s1_eb VCCD VCCD sky130_fd_pr__pfet_01v8 L=0.15 W=2 nf=1 ad=0.58 as=0.58 pd=4.58
+ ps=4.58 nrd=0.145 nrs=0.145 sa=0 sb=0 sd=0 mult=1 m=1
XMN_2eb s2_eb s1_eb VSSIO VSSIO sky130_fd_pr__nfet_01v8 L=0.15 W=1 nf=1 ad=0.29 as=0.29 pd=2.58
+ ps=2.58 nrd=0.29 nrs=0.29 sa=0 sb=0 sd=0 mult=1 m=1
XMP_3peb XPB s2_eb VCCD VCCD sky130_fd_pr__pfet_01v8 L=0.15 W=1 nf=1 ad=0.29 as=0.29 pd=2.58 ps=2.58
+ nrd=0.29 nrs=0.29 sa=0 sb=0 sd=0 mult=1 m=1
XMN_3peb XPB s2_eb VSSIO VSSIO sky130_fd_pr__nfet_01v8 L=0.15 W=0.5 nf=1 ad=0.145 as=0.145 pd=1.58
+ ps=1.58 nrd=0.58 nrs=0.58 sa=0 sb=0 sd=0 mult=1 m=1
XMP_3neb XNB s2_eb VCCD VCCD sky130_fd_pr__pfet_01v8 L=0.15 W=1 nf=1 ad=0.29 as=0.29 pd=2.58 ps=2.58
+ nrd=0.29 nrs=0.29 sa=0 sb=0 sd=0 mult=1 m=1
XMN_3neb XNB s2_eb VSSIO VSSIO sky130_fd_pr__nfet_01v8 L=0.15 W=0.5 nf=1 ad=0.145 as=0.145 pd=1.58
+ ps=1.58 nrd=0.58 nrs=0.58 sa=0 sb=0 sd=0 mult=1 m=1
.ends
