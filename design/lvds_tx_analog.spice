** sch_path: /home/ubuntu/GitHub/sky130-lvds-tx/.loom/worktrees/issue-20/design/lvds_tx_analog.sch
.subckt lvds_tx_analog D0 D0B D1 D1B CLK EN EM0 EM1 IREF VCMREF PADP PADN VCCD VDDIO VSSIO
*.ipin D0
*.ipin D0B
*.ipin D1
*.ipin D1B
*.ipin CLK
*.ipin EN
*.ipin EM0
*.ipin EM1
*.ipin IREF
*.ipin VCMREF
*.iopin PADP
*.iopin PADN
*.iopin VCCD
*.iopin VDDIO
*.iopin VSSIO
xmux D0 D0B D1 D1B CLK Q QB VCCD VSSIO ddr_mux
xmuxp D1 D1B D0 D0B CLK PREV PREVB VCCD VSSIO ddr_mux
xpre Q QB PREVB PREV EN GPA GNA GPB GNB XPA XNA XPB XNB VCCD VSSIO predriver
xdrv GPA GPB GNA GNB XPA XPB XNA XNB EN EM0 EM1 IREF VCMREF PADP PADN VCCD VDDIO VSSIO driver
xpadp PADP VSSIO pad_cell
xpadn PADN VSSIO pad_cell
.ends

* expanding   symbol:  ddr_mux.sym # of pins=9
** sym_path: /home/ubuntu/GitHub/sky130-lvds-tx/.loom/worktrees/issue-20/design/ddr_mux/ddr_mux.sym
** sch_path: /home/ubuntu/GitHub/sky130-lvds-tx/.loom/worktrees/issue-20/design/ddr_mux/ddr_mux.sch
.subckt ddr_mux D0 D0B D1 D1B CLK Q QB VCCD VSSIO
*.ipin D0
*.ipin D0B
*.ipin D1
*.ipin D1B
*.ipin CLK
*.opin Q
*.opin QB
*.iopin VCCD
*.iopin VSSIO
XMP_ck CLKB CLK VCCD VCCD sky130_fd_pr__pfet_01v8 L=0.15 W=1 nf=1 ad=0.29 as=0.29 pd=2.58 ps=2.58
+ nrd=0.29 nrs=0.29 sa=0 sb=0 sd=0 mult=1 m=1
XMN_ck CLKB CLK VSSIO VSSIO sky130_fd_pr__nfet_01v8 L=0.15 W=0.5 nf=1 ad=0.145 as=0.145 pd=1.58
+ ps=1.58 nrd=0.58 nrs=0.58 sa=0 sb=0 sd=0 mult=1 m=1
XMPD_a0 pm_a0 D0 VCCD VCCD sky130_fd_pr__pfet_01v8 L=0.15 W=2 nf=2 ad=0.29 as=0.58 pd=2.58 ps=5.16
+ nrd=0.145 nrs=0.145 sa=0 sb=0 sd=0 mult=1 m=1
XMPE_a0 QB CLKB pm_a0 VCCD sky130_fd_pr__pfet_01v8 L=0.15 W=2 nf=2 ad=0.29 as=0.58 pd=2.58 ps=5.16
+ nrd=0.145 nrs=0.145 sa=0 sb=0 sd=0 mult=1 m=1
XMNE_a0 QB CLK nm_a0 VSSIO sky130_fd_pr__nfet_01v8 L=0.15 W=1 nf=1 ad=0.29 as=0.29 pd=2.58 ps=2.58
+ nrd=0.29 nrs=0.29 sa=0 sb=0 sd=0 mult=1 m=1
XMND_a0 nm_a0 D0 VSSIO VSSIO sky130_fd_pr__nfet_01v8 L=0.15 W=1 nf=1 ad=0.29 as=0.29 pd=2.58 ps=2.58
+ nrd=0.29 nrs=0.29 sa=0 sb=0 sd=0 mult=1 m=1
XMPD_a1 pm_a1 D1 VCCD VCCD sky130_fd_pr__pfet_01v8 L=0.15 W=2 nf=2 ad=0.29 as=0.58 pd=2.58 ps=5.16
+ nrd=0.145 nrs=0.145 sa=0 sb=0 sd=0 mult=1 m=1
XMPE_a1 QB CLK pm_a1 VCCD sky130_fd_pr__pfet_01v8 L=0.15 W=2 nf=2 ad=0.29 as=0.58 pd=2.58 ps=5.16
+ nrd=0.145 nrs=0.145 sa=0 sb=0 sd=0 mult=1 m=1
XMNE_a1 QB CLKB nm_a1 VSSIO sky130_fd_pr__nfet_01v8 L=0.15 W=1 nf=1 ad=0.29 as=0.29 pd=2.58 ps=2.58
+ nrd=0.29 nrs=0.29 sa=0 sb=0 sd=0 mult=1 m=1
XMND_a1 nm_a1 D1 VSSIO VSSIO sky130_fd_pr__nfet_01v8 L=0.15 W=1 nf=1 ad=0.29 as=0.29 pd=2.58 ps=2.58
+ nrd=0.29 nrs=0.29 sa=0 sb=0 sd=0 mult=1 m=1
XMPD_b0 pm_b0 D0B VCCD VCCD sky130_fd_pr__pfet_01v8 L=0.15 W=2 nf=2 ad=0.29 as=0.58 pd=2.58 ps=5.16
+ nrd=0.145 nrs=0.145 sa=0 sb=0 sd=0 mult=1 m=1
XMPE_b0 Q CLKB pm_b0 VCCD sky130_fd_pr__pfet_01v8 L=0.15 W=2 nf=2 ad=0.29 as=0.58 pd=2.58 ps=5.16
+ nrd=0.145 nrs=0.145 sa=0 sb=0 sd=0 mult=1 m=1
XMNE_b0 Q CLK nm_b0 VSSIO sky130_fd_pr__nfet_01v8 L=0.15 W=1 nf=1 ad=0.29 as=0.29 pd=2.58 ps=2.58
+ nrd=0.29 nrs=0.29 sa=0 sb=0 sd=0 mult=1 m=1
XMND_b0 nm_b0 D0B VSSIO VSSIO sky130_fd_pr__nfet_01v8 L=0.15 W=1 nf=1 ad=0.29 as=0.29 pd=2.58
+ ps=2.58 nrd=0.29 nrs=0.29 sa=0 sb=0 sd=0 mult=1 m=1
XMPD_b1 pm_b1 D1B VCCD VCCD sky130_fd_pr__pfet_01v8 L=0.15 W=2 nf=2 ad=0.29 as=0.58 pd=2.58 ps=5.16
+ nrd=0.145 nrs=0.145 sa=0 sb=0 sd=0 mult=1 m=1
XMPE_b1 Q CLK pm_b1 VCCD sky130_fd_pr__pfet_01v8 L=0.15 W=2 nf=2 ad=0.29 as=0.58 pd=2.58 ps=5.16
+ nrd=0.145 nrs=0.145 sa=0 sb=0 sd=0 mult=1 m=1
XMNE_b1 Q CLKB nm_b1 VSSIO sky130_fd_pr__nfet_01v8 L=0.15 W=1 nf=1 ad=0.29 as=0.29 pd=2.58 ps=2.58
+ nrd=0.29 nrs=0.29 sa=0 sb=0 sd=0 mult=1 m=1
XMND_b1 nm_b1 D1B VSSIO VSSIO sky130_fd_pr__nfet_01v8 L=0.15 W=1 nf=1 ad=0.29 as=0.29 pd=2.58
+ ps=2.58 nrd=0.29 nrs=0.29 sa=0 sb=0 sd=0 mult=1 m=1
.ends

* expanding   symbol:  predriver.sym # of pins=15
** sym_path: /home/ubuntu/GitHub/sky130-lvds-tx/.loom/worktrees/issue-20/design/predriver/predriver.sym
** sch_path: /home/ubuntu/GitHub/sky130-lvds-tx/.loom/worktrees/issue-20/design/predriver/predriver.sch
.subckt predriver Q QB PQ PQB EN GPA GNA GPB GNB XPA XNA XPB XNB VCCD VSSIO
*.ipin Q
*.ipin QB
*.ipin PQ
*.ipin PQB
*.ipin EN
*.opin GPA
*.opin GNA
*.opin GPB
*.opin GNB
*.opin XPA
*.opin XNA
*.opin XPB
*.opin XNB
*.iopin VCCD
*.iopin VSSIO
XMP_enb ENB EN VCCD VCCD sky130_fd_pr__pfet_01v8 L=0.15 W=1 nf=1 ad=0.29 as=0.29 pd=2.58 ps=2.58
+ nrd=0.29 nrs=0.29 sa=0 sb=0 sd=0 mult=1 m=1
XMN_enb ENB EN VSSIO VSSIO sky130_fd_pr__nfet_01v8 L=0.15 W=0.5 nf=1 ad=0.145 as=0.145 pd=1.58
+ ps=1.58 nrd=0.58 nrs=0.58 sa=0 sb=0 sd=0 mult=1 m=1
XMPA_gma g_ma QB VCCD VCCD sky130_fd_pr__pfet_01v8 L=0.15 W=1 nf=1 ad=0.29 as=0.29 pd=2.58 ps=2.58
+ nrd=0.29 nrs=0.29 sa=0 sb=0 sd=0 mult=1 m=1
XMPB_gma g_ma EN VCCD VCCD sky130_fd_pr__pfet_01v8 L=0.15 W=1 nf=1 ad=0.29 as=0.29 pd=2.58 ps=2.58
+ nrd=0.29 nrs=0.29 sa=0 sb=0 sd=0 mult=1 m=1
XMNA_gma g_ma QB n_gma VSSIO sky130_fd_pr__nfet_01v8 L=0.15 W=1 nf=1 ad=0.29 as=0.29 pd=2.58 ps=2.58
+ nrd=0.29 nrs=0.29 sa=0 sb=0 sd=0 mult=1 m=1
XMNB_gma n_gma EN VSSIO VSSIO sky130_fd_pr__nfet_01v8 L=0.15 W=1 nf=1 ad=0.29 as=0.29 pd=2.58
+ ps=2.58 nrd=0.29 nrs=0.29 sa=0 sb=0 sd=0 mult=1 m=1
XMP_1ma s1_ma g_ma VCCD VCCD sky130_fd_pr__pfet_01v8 L=0.15 W=1 nf=1 ad=0.29 as=0.29 pd=2.58 ps=2.58
+ nrd=0.29 nrs=0.29 sa=0 sb=0 sd=0 mult=1 m=1
XMN_1ma s1_ma g_ma VSSIO VSSIO sky130_fd_pr__nfet_01v8 L=0.15 W=0.5 nf=1 ad=0.145 as=0.145 pd=1.58
+ ps=1.58 nrd=0.58 nrs=0.58 sa=0 sb=0 sd=0 mult=1 m=1
XMP_2ma s2_ma s1_ma VCCD VCCD sky130_fd_pr__pfet_01v8 L=0.15 W=2 nf=1 ad=0.58 as=0.58 pd=4.58
+ ps=4.58 nrd=0.145 nrs=0.145 sa=0 sb=0 sd=0 mult=1 m=1
XMN_2ma s2_ma s1_ma VSSIO VSSIO sky130_fd_pr__nfet_01v8 L=0.15 W=1 nf=1 ad=0.29 as=0.29 pd=2.58
+ ps=2.58 nrd=0.29 nrs=0.29 sa=0 sb=0 sd=0 mult=1 m=1
XMP_3pma GPA s2_ma VCCD VCCD sky130_fd_pr__pfet_01v8 L=0.15 W=11 nf=2 ad=1.595 as=3.19 pd=11.58
+ ps=23.16 nrd=0.0264 nrs=0.0264 sa=0 sb=0 sd=0 mult=1 m=1
XMN_3pma GPA s2_ma VSSIO VSSIO sky130_fd_pr__nfet_01v8 L=0.15 W=5.5 nf=1 ad=1.595 as=1.595 pd=11.58
+ ps=11.58 nrd=0.0527 nrs=0.0527 sa=0 sb=0 sd=0 mult=1 m=1
XMP_3nma GNA s2_ma VCCD VCCD sky130_fd_pr__pfet_01v8 L=0.15 W=11 nf=2 ad=1.595 as=3.19 pd=11.58
+ ps=23.16 nrd=0.0264 nrs=0.0264 sa=0 sb=0 sd=0 mult=1 m=1
XMN_3nma GNA s2_ma VSSIO VSSIO sky130_fd_pr__nfet_01v8 L=0.15 W=5.5 nf=1 ad=1.595 as=1.595 pd=11.58
+ ps=11.58 nrd=0.0527 nrs=0.0527 sa=0 sb=0 sd=0 mult=1 m=1
XMPA_gmb n_gmb Q VCCD VCCD sky130_fd_pr__pfet_01v8 L=0.15 W=2 nf=1 ad=0.58 as=0.58 pd=4.58 ps=4.58
+ nrd=0.145 nrs=0.145 sa=0 sb=0 sd=0 mult=1 m=1
XMPB_gmb g_mb ENB n_gmb VCCD sky130_fd_pr__pfet_01v8 L=0.15 W=2 nf=1 ad=0.58 as=0.58 pd=4.58 ps=4.58
+ nrd=0.145 nrs=0.145 sa=0 sb=0 sd=0 mult=1 m=1
XMNA_gmb g_mb Q VSSIO VSSIO sky130_fd_pr__nfet_01v8 L=0.15 W=0.5 nf=1 ad=0.145 as=0.145 pd=1.58
+ ps=1.58 nrd=0.58 nrs=0.58 sa=0 sb=0 sd=0 mult=1 m=1
XMNB_gmb g_mb ENB VSSIO VSSIO sky130_fd_pr__nfet_01v8 L=0.15 W=0.5 nf=1 ad=0.145 as=0.145 pd=1.58
+ ps=1.58 nrd=0.58 nrs=0.58 sa=0 sb=0 sd=0 mult=1 m=1
XMP_1mb s1_mb g_mb VCCD VCCD sky130_fd_pr__pfet_01v8 L=0.15 W=1 nf=1 ad=0.29 as=0.29 pd=2.58 ps=2.58
+ nrd=0.29 nrs=0.29 sa=0 sb=0 sd=0 mult=1 m=1
XMN_1mb s1_mb g_mb VSSIO VSSIO sky130_fd_pr__nfet_01v8 L=0.15 W=0.5 nf=1 ad=0.145 as=0.145 pd=1.58
+ ps=1.58 nrd=0.58 nrs=0.58 sa=0 sb=0 sd=0 mult=1 m=1
XMP_2mb s2_mb s1_mb VCCD VCCD sky130_fd_pr__pfet_01v8 L=0.15 W=2 nf=1 ad=0.58 as=0.58 pd=4.58
+ ps=4.58 nrd=0.145 nrs=0.145 sa=0 sb=0 sd=0 mult=1 m=1
XMN_2mb s2_mb s1_mb VSSIO VSSIO sky130_fd_pr__nfet_01v8 L=0.15 W=1 nf=1 ad=0.29 as=0.29 pd=2.58
+ ps=2.58 nrd=0.29 nrs=0.29 sa=0 sb=0 sd=0 mult=1 m=1
XMP_3pmb GPB s2_mb VCCD VCCD sky130_fd_pr__pfet_01v8 L=0.15 W=11 nf=2 ad=1.595 as=3.19 pd=11.58
+ ps=23.16 nrd=0.0264 nrs=0.0264 sa=0 sb=0 sd=0 mult=1 m=1
XMN_3pmb GPB s2_mb VSSIO VSSIO sky130_fd_pr__nfet_01v8 L=0.15 W=5.5 nf=1 ad=1.595 as=1.595 pd=11.58
+ ps=11.58 nrd=0.0527 nrs=0.0527 sa=0 sb=0 sd=0 mult=1 m=1
XMP_3nmb GNB s2_mb VCCD VCCD sky130_fd_pr__pfet_01v8 L=0.15 W=11 nf=2 ad=1.595 as=3.19 pd=11.58
+ ps=23.16 nrd=0.0264 nrs=0.0264 sa=0 sb=0 sd=0 mult=1 m=1
XMN_3nmb GNB s2_mb VSSIO VSSIO sky130_fd_pr__nfet_01v8 L=0.15 W=5.5 nf=1 ad=1.595 as=1.595 pd=11.58
+ ps=11.58 nrd=0.0527 nrs=0.0527 sa=0 sb=0 sd=0 mult=1 m=1
XMPA_gea g_ea PQB VCCD VCCD sky130_fd_pr__pfet_01v8 L=0.15 W=1 nf=1 ad=0.29 as=0.29 pd=2.58 ps=2.58
+ nrd=0.29 nrs=0.29 sa=0 sb=0 sd=0 mult=1 m=1
XMPB_gea g_ea EN VCCD VCCD sky130_fd_pr__pfet_01v8 L=0.15 W=1 nf=1 ad=0.29 as=0.29 pd=2.58 ps=2.58
+ nrd=0.29 nrs=0.29 sa=0 sb=0 sd=0 mult=1 m=1
XMNA_gea g_ea PQB n_gea VSSIO sky130_fd_pr__nfet_01v8 L=0.15 W=1 nf=1 ad=0.29 as=0.29 pd=2.58
+ ps=2.58 nrd=0.29 nrs=0.29 sa=0 sb=0 sd=0 mult=1 m=1
XMNB_gea n_gea EN VSSIO VSSIO sky130_fd_pr__nfet_01v8 L=0.15 W=1 nf=1 ad=0.29 as=0.29 pd=2.58
+ ps=2.58 nrd=0.29 nrs=0.29 sa=0 sb=0 sd=0 mult=1 m=1
XMP_1ea s1_ea g_ea VCCD VCCD sky130_fd_pr__pfet_01v8 L=0.15 W=1 nf=1 ad=0.29 as=0.29 pd=2.58 ps=2.58
+ nrd=0.29 nrs=0.29 sa=0 sb=0 sd=0 mult=1 m=1
XMN_1ea s1_ea g_ea VSSIO VSSIO sky130_fd_pr__nfet_01v8 L=0.15 W=0.5 nf=1 ad=0.145 as=0.145 pd=1.58
+ ps=1.58 nrd=0.58 nrs=0.58 sa=0 sb=0 sd=0 mult=1 m=1
XMP_2ea s2_ea s1_ea VCCD VCCD sky130_fd_pr__pfet_01v8 L=0.15 W=2 nf=1 ad=0.58 as=0.58 pd=4.58
+ ps=4.58 nrd=0.145 nrs=0.145 sa=0 sb=0 sd=0 mult=1 m=1
XMN_2ea s2_ea s1_ea VSSIO VSSIO sky130_fd_pr__nfet_01v8 L=0.15 W=1 nf=1 ad=0.29 as=0.29 pd=2.58
+ ps=2.58 nrd=0.29 nrs=0.29 sa=0 sb=0 sd=0 mult=1 m=1
XMP_3pea XPA s2_ea VCCD VCCD sky130_fd_pr__pfet_01v8 L=0.15 W=1 nf=1 ad=0.29 as=0.29 pd=2.58 ps=2.58
+ nrd=0.29 nrs=0.29 sa=0 sb=0 sd=0 mult=1 m=1
XMN_3pea XPA s2_ea VSSIO VSSIO sky130_fd_pr__nfet_01v8 L=0.15 W=0.5 nf=1 ad=0.145 as=0.145 pd=1.58
+ ps=1.58 nrd=0.58 nrs=0.58 sa=0 sb=0 sd=0 mult=1 m=1
XMP_3nea XNA s2_ea VCCD VCCD sky130_fd_pr__pfet_01v8 L=0.15 W=1 nf=1 ad=0.29 as=0.29 pd=2.58 ps=2.58
+ nrd=0.29 nrs=0.29 sa=0 sb=0 sd=0 mult=1 m=1
XMN_3nea XNA s2_ea VSSIO VSSIO sky130_fd_pr__nfet_01v8 L=0.15 W=0.5 nf=1 ad=0.145 as=0.145 pd=1.58
+ ps=1.58 nrd=0.58 nrs=0.58 sa=0 sb=0 sd=0 mult=1 m=1
XMPA_geb n_geb PQ VCCD VCCD sky130_fd_pr__pfet_01v8 L=0.15 W=2 nf=1 ad=0.58 as=0.58 pd=4.58 ps=4.58
+ nrd=0.145 nrs=0.145 sa=0 sb=0 sd=0 mult=1 m=1
XMPB_geb g_eb ENB n_geb VCCD sky130_fd_pr__pfet_01v8 L=0.15 W=2 nf=1 ad=0.58 as=0.58 pd=4.58 ps=4.58
+ nrd=0.145 nrs=0.145 sa=0 sb=0 sd=0 mult=1 m=1
XMNA_geb g_eb PQ VSSIO VSSIO sky130_fd_pr__nfet_01v8 L=0.15 W=0.5 nf=1 ad=0.145 as=0.145 pd=1.58
+ ps=1.58 nrd=0.58 nrs=0.58 sa=0 sb=0 sd=0 mult=1 m=1
XMNB_geb g_eb ENB VSSIO VSSIO sky130_fd_pr__nfet_01v8 L=0.15 W=0.5 nf=1 ad=0.145 as=0.145 pd=1.58
+ ps=1.58 nrd=0.58 nrs=0.58 sa=0 sb=0 sd=0 mult=1 m=1
XMP_1eb s1_eb g_eb VCCD VCCD sky130_fd_pr__pfet_01v8 L=0.15 W=1 nf=1 ad=0.29 as=0.29 pd=2.58 ps=2.58
+ nrd=0.29 nrs=0.29 sa=0 sb=0 sd=0 mult=1 m=1
XMN_1eb s1_eb g_eb VSSIO VSSIO sky130_fd_pr__nfet_01v8 L=0.15 W=0.5 nf=1 ad=0.145 as=0.145 pd=1.58
+ ps=1.58 nrd=0.58 nrs=0.58 sa=0 sb=0 sd=0 mult=1 m=1
XMP_2eb s2_eb s1_eb VCCD VCCD sky130_fd_pr__pfet_01v8 L=0.15 W=2 nf=1 ad=0.58 as=0.58 pd=4.58
+ ps=4.58 nrd=0.145 nrs=0.145 sa=0 sb=0 sd=0 mult=1 m=1
XMN_2eb s2_eb s1_eb VSSIO VSSIO sky130_fd_pr__nfet_01v8 L=0.15 W=1 nf=1 ad=0.29 as=0.29 pd=2.58
+ ps=2.58 nrd=0.29 nrs=0.29 sa=0 sb=0 sd=0 mult=1 m=1
XMP_3peb XPB s2_eb VCCD VCCD sky130_fd_pr__pfet_01v8 L=0.15 W=1 nf=1 ad=0.29 as=0.29 pd=2.58 ps=2.58
+ nrd=0.29 nrs=0.29 sa=0 sb=0 sd=0 mult=1 m=1
XMN_3peb XPB s2_eb VSSIO VSSIO sky130_fd_pr__nfet_01v8 L=0.15 W=0.5 nf=1 ad=0.145 as=0.145 pd=1.58
+ ps=1.58 nrd=0.58 nrs=0.58 sa=0 sb=0 sd=0 mult=1 m=1
XMP_3neb XNB s2_eb VCCD VCCD sky130_fd_pr__pfet_01v8 L=0.15 W=1 nf=1 ad=0.29 as=0.29 pd=2.58 ps=2.58
+ nrd=0.29 nrs=0.29 sa=0 sb=0 sd=0 mult=1 m=1
XMN_3neb XNB s2_eb VSSIO VSSIO sky130_fd_pr__nfet_01v8 L=0.15 W=0.5 nf=1 ad=0.145 as=0.145 pd=1.58
+ ps=1.58 nrd=0.58 nrs=0.58 sa=0 sb=0 sd=0 mult=1 m=1
.ends

* expanding   symbol:  driver.sym # of pins=18
** sym_path: /home/ubuntu/GitHub/sky130-lvds-tx/.loom/worktrees/issue-20/design/driver/driver.sym
** sch_path: /home/ubuntu/GitHub/sky130-lvds-tx/.loom/worktrees/issue-20/design/driver/driver.sch
.subckt driver GPA GPB GNA GNB XPA XPB XNA XNB EN EM0 EM1 IREF VCMREF OUTP OUTN VCCD VDDIO VSSIO
*.ipin GPA
*.ipin GPB
*.ipin GNA
*.ipin GNB
*.ipin XPA
*.ipin XPB
*.ipin XNA
*.ipin XNB
*.ipin EN
*.ipin EM0
*.ipin EM1
*.ipin IREF
*.ipin VCMREF
*.iopin OUTP
*.iopin OUTN
*.iopin VCCD
*.iopin VDDIO
*.iopin VSSIO
XMNB1 IREF IREF VSSIO VSSIO sky130_fd_pr__nfet_g5v0d10v5 L=1 W=2 nf=1 ad=0.58 as=0.58 pd=4.58
+ ps=4.58 nrd=0.145 nrs=0.145 sa=0 sb=0 sd=0 mult=1 m=1
XMNB2 BIASP IREF VSSIO VSSIO sky130_fd_pr__nfet_g5v0d10v5 L=1 W=2 nf=1 ad=0.58 as=0.58 pd=4.58
+ ps=4.58 nrd=0.145 nrs=0.145 sa=0 sb=0 sd=0 mult=1 m=1
XMPB BIASP BIASP VDDIO VDDIO sky130_fd_pr__pfet_g5v0d10v5 L=1 W=2 nf=1 ad=0.58 as=0.58 pd=4.58
+ ps=4.58 nrd=0.145 nrs=0.145 sa=0 sb=0 sd=0 mult=1 m=1
XMT TAIL IREF VSSIO VSSIO sky130_fd_pr__nfet_g5v0d10v5 L=1 W=4 nf=1 ad=1.16 as=1.16 pd=8.58 ps=8.58
+ nrd=0.0725 nrs=0.0725 sa=0 sb=0 sd=0 mult=1 m=1
XM1 N1 VCMS TAIL VSSIO sky130_fd_pr__nfet_g5v0d10v5 L=1 W=10 nf=1 ad=2.9 as=2.9 pd=20.58 ps=20.58
+ nrd=0.029 nrs=0.029 sa=0 sb=0 sd=0 mult=1 m=1
XM2 VCMFB VCMREF TAIL VSSIO sky130_fd_pr__nfet_g5v0d10v5 L=1 W=10 nf=1 ad=2.9 as=2.9 pd=20.58
+ ps=20.58 nrd=0.029 nrs=0.029 sa=0 sb=0 sd=0 mult=1 m=1
XML1 N1 N1 VDDIO VDDIO sky130_fd_pr__pfet_g5v0d10v5 L=1 W=4 nf=1 ad=1.16 as=1.16 pd=8.58 ps=8.58
+ nrd=0.0725 nrs=0.0725 sa=0 sb=0 sd=0 mult=1 m=1
XML2 VCMFB N1 VDDIO VDDIO sky130_fd_pr__pfet_g5v0d10v5 L=1 W=4 nf=1 ad=1.16 as=1.16 pd=8.58 ps=8.58
+ nrd=0.0725 nrs=0.0725 sa=0 sb=0 sd=0 mult=1 m=1
XCC VSSIO VCMFB VSSIO VSSIO sky130_fd_pr__nfet_g5v0d10v5 L=2 W=20 nf=1 ad=5.8 as=5.8 pd=40.58
+ ps=40.58 nrd=0.0145 nrs=0.0145 sa=0 sb=0 sd=0 mult=1 m=1
XRS1 VCMS OUTP VSSIO sky130_fd_pr__res_high_po_1p41 L=15 mult=1 m=1
XRS2 VCMS OUTN VSSIO sky130_fd_pr__res_high_po_1p41 L=15 mult=1 m=1
xsel_en EN BIASP VCMFB PGM NGM VCCD VDDIO VSSIO drv_sel
xsel_e0 EM0 BIASP VCMFB PGE0 NGE0 VCCD VDDIO VSSIO drv_sel
xsel_e1 EM1 BIASP VCMFB PGE1 NGE1 VCCD VDDIO VSSIO drv_sel
xsl_main GPA GPB GNA GNB PGM NGM OUTP OUTN VCCD VDDIO VSSIO drv_slice SCALE=11
xsl_e0 XPA XPB XNA XNB PGE0 NGE0 OUTP OUTN VCCD VDDIO VSSIO drv_slice SCALE=1
xsl_e1a XPA XPB XNA XNB PGE1 NGE1 OUTP OUTN VCCD VDDIO VSSIO drv_slice SCALE=1
xsl_e1b XPA XPB XNA XNB PGE1 NGE1 OUTP OUTN VCCD VDDIO VSSIO drv_slice SCALE=1
.ends

* expanding   symbol:  pad_cell.sym # of pins=2
** sym_path: /home/ubuntu/GitHub/sky130-lvds-tx/.loom/worktrees/issue-20/design/pad_cell/pad_cell.sym
** sch_path: /home/ubuntu/GitHub/sky130-lvds-tx/.loom/worktrees/issue-20/design/pad_cell/pad_cell.sch
.subckt pad_cell PAD VSSIO
*.iopin PAD
*.iopin VSSIO
XD1 VSSIO PAD sky130_fd_pr__diode_pw2nd_11v0 area=4e14 perim=8e7
XMESD PAD VSSIO VSSIO VSSIO sky130_fd_pr__esd_nfet_g5v0d10v5 L=0.55 W=21.5 nf=1 ad=6.235 as=6.235
+ pd=43.58 ps=43.58 nrd=0.0135 nrs=0.0135 sa=0 sb=0 sd=0 mult=4 m=4
.ends

* expanding   symbol:  drv_sel.sym # of pins=8
** sym_path: /home/ubuntu/GitHub/sky130-lvds-tx/.loom/worktrees/issue-20/design/driver/drv_sel.sym
** sch_path: /home/ubuntu/GitHub/sky130-lvds-tx/.loom/worktrees/issue-20/design/driver/drv_sel.sch
.subckt drv_sel SEL BIASP VCMFB PG NG VCCD VDDIO VSSIO
*.ipin SEL
*.iopin BIASP
*.iopin VCMFB
*.opin PG
*.opin NG
*.iopin VCCD
*.iopin VDDIO
*.iopin VSSIO
XMP_sb SELB SEL VCCD VCCD sky130_fd_pr__pfet_01v8 L=0.15 W=1 nf=1 ad=0.29 as=0.29 pd=2.58 ps=2.58
+ nrd=0.29 nrs=0.29 sa=0 sb=0 sd=0 mult=1 m=1
XMN_sb SELB SEL VSSIO VSSIO sky130_fd_pr__nfet_01v8 L=0.15 W=0.5 nf=1 ad=0.145 as=0.145 pd=1.58
+ ps=1.58 nrd=0.58 nrs=0.58 sa=0 sb=0 sd=0 mult=1 m=1
XMLN1 ENHB SEL VSSIO VSSIO sky130_fd_pr__nfet_g5v0d10v5 L=0.5 W=1 nf=1 ad=0.29 as=0.29 pd=2.58
+ ps=2.58 nrd=0.29 nrs=0.29 sa=0 sb=0 sd=0 mult=1 m=1
XMLN2 ENH SELB VSSIO VSSIO sky130_fd_pr__nfet_g5v0d10v5 L=0.5 W=1 nf=1 ad=0.29 as=0.29 pd=2.58
+ ps=2.58 nrd=0.29 nrs=0.29 sa=0 sb=0 sd=0 mult=1 m=1
XMLP1 ENHB ENH VDDIO VDDIO sky130_fd_pr__pfet_g5v0d10v5 L=0.5 W=0.5 nf=1 ad=0.145 as=0.145 pd=1.58
+ ps=1.58 nrd=0.58 nrs=0.58 sa=0 sb=0 sd=0 mult=1 m=1
XMLP2 ENH ENHB VDDIO VDDIO sky130_fd_pr__pfet_g5v0d10v5 L=0.5 W=0.5 nf=1 ad=0.145 as=0.145 pd=1.58
+ ps=1.58 nrd=0.58 nrs=0.58 sa=0 sb=0 sd=0 mult=1 m=1
XMPU PG ENH VDDIO VDDIO sky130_fd_pr__pfet_g5v0d10v5 L=0.5 W=1 nf=1 ad=0.29 as=0.29 pd=2.58 ps=2.58
+ nrd=0.29 nrs=0.29 sa=0 sb=0 sd=0 mult=1 m=1
XMPP PG ENHB BIASP VDDIO sky130_fd_pr__pfet_g5v0d10v5 L=0.5 W=4 nf=2 ad=0.58 as=1.16 pd=4.58 ps=9.16
+ nrd=0.0725 nrs=0.0725 sa=0 sb=0 sd=0 mult=1 m=1
XMND NG ENHB VSSIO VSSIO sky130_fd_pr__nfet_g5v0d10v5 L=0.5 W=1 nf=1 ad=0.29 as=0.29 pd=2.58 ps=2.58
+ nrd=0.29 nrs=0.29 sa=0 sb=0 sd=0 mult=1 m=1
XMNP NG ENH VCMFB VSSIO sky130_fd_pr__nfet_g5v0d10v5 L=0.5 W=4 nf=2 ad=0.58 as=1.16 pd=4.58 ps=9.16
+ nrd=0.0725 nrs=0.0725 sa=0 sb=0 sd=0 mult=1 m=1
.ends

* expanding   symbol:  drv_slice.sym # of pins=11
** sym_path: /home/ubuntu/GitHub/sky130-lvds-tx/.loom/worktrees/issue-20/design/driver/drv_slice.sym
** sch_path: /home/ubuntu/GitHub/sky130-lvds-tx/.loom/worktrees/issue-20/design/driver/drv_slice.sch
.subckt drv_slice GPA GPB GNA GNB PG NG OUTP OUTN VCCD VDDIO VSSIO  SCALE=1
*.ipin GPA
*.ipin GPB
*.ipin GNA
*.ipin GNB
*.ipin PG
*.ipin NG
*.iopin OUTP
*.iopin OUTN
*.iopin VCCD
*.iopin VDDIO
*.iopin VSSIO
XMPS TOP PG VDDIO VDDIO sky130_fd_pr__pfet_g5v0d10v5 L=1 W=12.8 nf=2 ad=1.856 as=3.712 pd=13.38 ps=26.76
+ nrd=0.0227 nrs=0.0227 sa=0 sb=0 sd=0 mult={SCALE} m={SCALE}
XMSPA OUTP GPA TOP WELL sky130_fd_pr__pfet_01v8 L=0.15 W=3.6 nf=4 ad=0.522 as=0.783 pd=4.76 ps=7.14 nrd=0.0806
+ nrs=0.0806 sa=0 sb=0 sd=0 mult={SCALE} m={SCALE}
XMSPB OUTN GPB TOP WELL sky130_fd_pr__pfet_01v8 L=0.15 W=3.6 nf=4 ad=0.522 as=0.783 pd=4.76 ps=7.14 nrd=0.0806
+ nrs=0.0806 sa=0 sb=0 sd=0 mult={SCALE} m={SCALE}
XMSNA OUTP GNA BOT VSSIO sky130_fd_pr__nfet_01v8 L=0.15 W=2.7 nf=3 ad=0.522 as=0.522 pd=4.76 ps=4.76
+ nrd=0.1074 nrs=0.1074 sa=0 sb=0 sd=0 mult={SCALE} m={SCALE}
XMSNB OUTN GNB BOT VSSIO sky130_fd_pr__nfet_01v8 L=0.15 W=2.7 nf=3 ad=0.522 as=0.522 pd=4.76 ps=4.76
+ nrd=0.1074 nrs=0.1074 sa=0 sb=0 sd=0 mult={SCALE} m={SCALE}
XMNS BOT NG VSSIO VSSIO sky130_fd_pr__nfet_g5v0d10v5 L=1 W=6 nf=1 ad=1.74 as=1.74 pd=12.58 ps=12.58 nrd=0.0483
+ nrs=0.0483 sa=0 sb=0 sd=0 mult={SCALE} m={SCALE}
XMWVA WELL OUTP VCCD WELL sky130_fd_pr__pfet_g5v0d10v5 L=0.5 W=0.5 nf=1 ad=0.145 as=0.145 pd=1.58
+ ps=1.58 nrd=0.58 nrs=0.58 sa=0 sb=0 sd=0 mult=1 m=1
XMWVB WELL OUTN VCCD WELL sky130_fd_pr__pfet_g5v0d10v5 L=0.5 W=0.5 nf=1 ad=0.145 as=0.145 pd=1.58
+ ps=1.58 nrd=0.58 nrs=0.58 sa=0 sb=0 sd=0 mult=1 m=1
XMWPA WELL VCCD OUTP WELL sky130_fd_pr__pfet_g5v0d10v5 L=0.5 W=0.5 nf=1 ad=0.145 as=0.145 pd=1.58
+ ps=1.58 nrd=0.58 nrs=0.58 sa=0 sb=0 sd=0 mult=1 m=1
XMWPB WELL VCCD OUTN WELL sky130_fd_pr__pfet_g5v0d10v5 L=0.5 W=0.5 nf=1 ad=0.145 as=0.145 pd=1.58
+ ps=1.58 nrd=0.58 nrs=0.58 sa=0 sb=0 sd=0 mult=1 m=1
XMGTA GPA VCCD WELL WELL sky130_fd_pr__pfet_g5v0d10v5 L=0.5 W=0.5 nf=1 ad=0.145 as=0.145 pd=1.58
+ ps=1.58 nrd=0.58 nrs=0.58 sa=0 sb=0 sd=0 mult=1 m=1
XMGTB GPB VCCD WELL WELL sky130_fd_pr__pfet_g5v0d10v5 L=0.5 W=0.5 nf=1 ad=0.145 as=0.145 pd=1.58
+ ps=1.58 nrd=0.58 nrs=0.58 sa=0 sb=0 sd=0 mult=1 m=1
.ends
