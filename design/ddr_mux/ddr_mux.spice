** sch_path: /home/ubuntu/GitHub/sky130-lvds-tx/.loom/worktrees/issue-20/design/ddr_mux/ddr_mux.sch
.subckt ddr_mux D0 D0B D1 D1B CLK Q QB VCCD VSSIO
*.ipin D0
*.ipin D0B
*.ipin D1
*.ipin D1B
*.ipin CLK
*.opin Q
*.opin QB
*.iopin VCCD
*.iopin VSSIO
XMP_ck CLKB CLK VCCD VCCD sky130_fd_pr__pfet_01v8 L=0.15 W=1 nf=1 ad=0.29 as=0.29 pd=2.58 ps=2.58
+ nrd=0.29 nrs=0.29 sa=0 sb=0 sd=0 mult=1 m=1
XMN_ck CLKB CLK VSSIO VSSIO sky130_fd_pr__nfet_01v8 L=0.15 W=0.5 nf=1 ad=0.145 as=0.145 pd=1.58
+ ps=1.58 nrd=0.58 nrs=0.58 sa=0 sb=0 sd=0 mult=1 m=1
XMPD_a0 pm_a0 D0 VCCD VCCD sky130_fd_pr__pfet_01v8 L=0.15 W=2 nf=2 ad=0.29 as=0.58 pd=2.58 ps=5.16
+ nrd=0.145 nrs=0.145 sa=0 sb=0 sd=0 mult=1 m=1
XMPE_a0 QB CLKB pm_a0 VCCD sky130_fd_pr__pfet_01v8 L=0.15 W=2 nf=2 ad=0.29 as=0.58 pd=2.58 ps=5.16
+ nrd=0.145 nrs=0.145 sa=0 sb=0 sd=0 mult=1 m=1
XMNE_a0 QB CLK nm_a0 VSSIO sky130_fd_pr__nfet_01v8 L=0.15 W=1 nf=1 ad=0.29 as=0.29 pd=2.58 ps=2.58
+ nrd=0.29 nrs=0.29 sa=0 sb=0 sd=0 mult=1 m=1
XMND_a0 nm_a0 D0 VSSIO VSSIO sky130_fd_pr__nfet_01v8 L=0.15 W=1 nf=1 ad=0.29 as=0.29 pd=2.58 ps=2.58
+ nrd=0.29 nrs=0.29 sa=0 sb=0 sd=0 mult=1 m=1
XMPD_a1 pm_a1 D1 VCCD VCCD sky130_fd_pr__pfet_01v8 L=0.15 W=2 nf=2 ad=0.29 as=0.58 pd=2.58 ps=5.16
+ nrd=0.145 nrs=0.145 sa=0 sb=0 sd=0 mult=1 m=1
XMPE_a1 QB CLK pm_a1 VCCD sky130_fd_pr__pfet_01v8 L=0.15 W=2 nf=2 ad=0.29 as=0.58 pd=2.58 ps=5.16
+ nrd=0.145 nrs=0.145 sa=0 sb=0 sd=0 mult=1 m=1
XMNE_a1 QB CLKB nm_a1 VSSIO sky130_fd_pr__nfet_01v8 L=0.15 W=1 nf=1 ad=0.29 as=0.29 pd=2.58 ps=2.58
+ nrd=0.29 nrs=0.29 sa=0 sb=0 sd=0 mult=1 m=1
XMND_a1 nm_a1 D1 VSSIO VSSIO sky130_fd_pr__nfet_01v8 L=0.15 W=1 nf=1 ad=0.29 as=0.29 pd=2.58 ps=2.58
+ nrd=0.29 nrs=0.29 sa=0 sb=0 sd=0 mult=1 m=1
XMPD_b0 pm_b0 D0B VCCD VCCD sky130_fd_pr__pfet_01v8 L=0.15 W=2 nf=2 ad=0.29 as=0.58 pd=2.58 ps=5.16
+ nrd=0.145 nrs=0.145 sa=0 sb=0 sd=0 mult=1 m=1
XMPE_b0 Q CLKB pm_b0 VCCD sky130_fd_pr__pfet_01v8 L=0.15 W=2 nf=2 ad=0.29 as=0.58 pd=2.58 ps=5.16
+ nrd=0.145 nrs=0.145 sa=0 sb=0 sd=0 mult=1 m=1
XMNE_b0 Q CLK nm_b0 VSSIO sky130_fd_pr__nfet_01v8 L=0.15 W=1 nf=1 ad=0.29 as=0.29 pd=2.58 ps=2.58
+ nrd=0.29 nrs=0.29 sa=0 sb=0 sd=0 mult=1 m=1
XMND_b0 nm_b0 D0B VSSIO VSSIO sky130_fd_pr__nfet_01v8 L=0.15 W=1 nf=1 ad=0.29 as=0.29 pd=2.58
+ ps=2.58 nrd=0.29 nrs=0.29 sa=0 sb=0 sd=0 mult=1 m=1
XMPD_b1 pm_b1 D1B VCCD VCCD sky130_fd_pr__pfet_01v8 L=0.15 W=2 nf=2 ad=0.29 as=0.58 pd=2.58 ps=5.16
+ nrd=0.145 nrs=0.145 sa=0 sb=0 sd=0 mult=1 m=1
XMPE_b1 Q CLK pm_b1 VCCD sky130_fd_pr__pfet_01v8 L=0.15 W=2 nf=2 ad=0.29 as=0.58 pd=2.58 ps=5.16
+ nrd=0.145 nrs=0.145 sa=0 sb=0 sd=0 mult=1 m=1
XMNE_b1 Q CLKB nm_b1 VSSIO sky130_fd_pr__nfet_01v8 L=0.15 W=1 nf=1 ad=0.29 as=0.29 pd=2.58 ps=2.58
+ nrd=0.29 nrs=0.29 sa=0 sb=0 sd=0 mult=1 m=1
XMND_b1 nm_b1 D1B VSSIO VSSIO sky130_fd_pr__nfet_01v8 L=0.15 W=1 nf=1 ad=0.29 as=0.29 pd=2.58
+ ps=2.58 nrd=0.29 nrs=0.29 sa=0 sb=0 sd=0 mult=1 m=1
.ends
